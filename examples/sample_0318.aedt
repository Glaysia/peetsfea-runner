# Ansys Electronics Desktop project, version 2025.2
materials:
  vacuum: permittivity=1
  copper: permeability=0.999991 conductivity=58000000
  FR4_epoxy: permittivity=4.4 dielectric_loss_tangent=0.02
  air: permittivity=1.0006 permeability=1.0000004
surface materials:
  Steel-oxidised-surface

design pcb_design (HFSS, HFSS Terminal Network, model units mm)
variables:
  coil_groups_0__count_mode = 2
  coil_groups_1__count_range = 5
  coil_groups_params_rx_dd_band_ratio = 0.28421053
  coil_groups_params_rx_dd_metal_ratio = 0.3
  coil_groups_params_rx_dd_turn_count_max = 2
  coil_groups_params_tx_dd_band_ratio = 0.32368421
  coil_groups_params_tx_dd_metal_ratio = 0.58125
  coil_groups_params_tx_dd_turn_count_max = 3
  coil_groups_params_tx_vertical_band_ratio = 0.39736842
  coil_groups_params_tx_vertical_metal_ratio = 0.5125
  coil_groups_params_tx_vertical_turn_count_max = 2
  coil_placement_tx_dd_top_clearance_ratio = 0.033333333mm
  coil_placement_tx_vertical_layout_mode = 1
  coil_placement_tx_vertical_mode2_x_ratio_to_tx_dd_center = 0.9
  coil_shape_inner_margin_x = 5.4285714mm
  coil_shape_inner_margin_y = 5.4285714mm
  coil_shape_rx_dd_outer_x = 92.666667mm
  coil_shape_rx_dd_outer_y = 113.84615mm
  coil_shape_tx_dd_outer_x = 146.36364mm
  coil_shape_tx_dd_outer_y = 90.512821mm
  coil_shape_tx_vertical_outer_y = 61.794872mm
  coil_spacing_rx_dd_pair_spacing_ratio = 0.005
  coil_spacing_tx_dd_pair_spacing_ratio = 0.035
  coil_spacing_tx_vertical_center_gap_mm = 3.5314286mm
  coil_spacing_tx_vertical_mode2_pair_spacing_ratio = 0.02875
  ferrite_present = 0
  ferrite_tx_gap_mm = 5.6428571mm
  pcb_spacing_tx_main_1_z_from_tx_main_0_mm = 5.5mm
  tx_region_z_parts_dd_z_mm = 19.615385mm
  tx_region_z_parts_vertical_z_mm = 7mm
geometry:
  scene_floor_000000_e837_cab7_1 [vacuum, non-model] = box(corner=(0mm, -2500mm, -300mm), size=(5000mm, 5000mm, 300mm))
  scene_shelf_000000_e837_cab7_1 [vacuum, non-model] = box(corner=(0mm, -921mm, 0mm), size=(400mm, 1842mm, 461mm))
  scene_wall_000000_e837_cab7_1 [vacuum, non-model] = box(corner=(-200mm, -2000mm, 0mm), size=(200mm, 4000mm, 3000mm))
  scene_tv_000000_e837_cab7_1 [vacuum, non-model] = box(corner=(0mm, -921mm, 600mm), size=(9mm, 1842mm, 1055mm))
  scene_tx_region_max_000000_e837_cab7_1 [vacuum, non-model] = box(corner=(0mm, -140mm, 461mm), size=(160mm, 280mm, 90mm))
  scene_tx_region_vertical_000000_e837_cab7_1 [vacuum, non-model] = box(corner=(0mm, -140mm, 544mm), size=(160mm, 280mm, 7mm))
  scene_tx_region_dd_000000_e837_cab7_1 [vacuum, non-model] = box(corner=(0mm, -140mm, 524.38462mm), size=(160mm, 280mm, 19.615385mm))
  scene_rx_region_max_000000_e837_cab7_1 [vacuum, non-model] = box(corner=(0mm, -280mm, 601mm), size=(4mm, 560mm, 360mm))
  scene_rx_region_actual_000000_e837_cab7_1 [vacuum, non-model] = box(corner=(0mm, -280mm, 601mm), size=(4mm, 560mm, 360mm))
  coil_tx_dd_g1_b0_000000_e837_cab7_1 = polyline(z=543.31115mm, xy in mm: (2.8382022, 95.412821) (2.8382022, 7.7382022) (143.52543, 7.7382022) (143.52543, 82.808761) (133.75958, 82.808761) (12.604059, 82.808761) (12.604059, 17.504059) (133.75958, 17.504059) (133.75958, 73.042904) (123.99372, 73.042904) (22.369916, 73.042904) (22.369916, 24.431714), section rectangle width=5.6764044mm height=0.035mm)
  coil_tx_dd_g1_b0_000000_e837_cab7_1_1 = coil_tx_dd_g1_b0_000000_e837_cab7_1.duplicate_mirror(point=(73.181818mm, 0mm, 543.31115mm), normal=(0mm, 1mm, 0mm))
  coil_tx_vertical_g0_b2_000000_e837_cab7_1 = polyline(y=-7.0628571mm, xz in mm: (0.3563898, 550.64361) (146.00725, 550.64361) (146.00725, 544.35639) (0.3563898, 544.35639) (0.3563898, 549.25282) (1.7471793, 549.25282) (144.61646, 549.25282) (144.61646, 545.74718) (1.7471793, 545.74718), section rectangle width=0.71277961mm height=0.035mm)
  coil_tx_vertical_g1_b2_000000_e837_cab7_1 = polyline(y=-3.5314286mm, xz in mm: (0.3563898, 550.64361) (146.00725, 550.64361) (146.00725, 544.35639) (0.3563898, 544.35639) (0.3563898, 549.25282) (1.7471793, 549.25282) (144.61646, 549.25282) (144.61646, 545.74718) (1.7471793, 545.74718), section rectangle width=0.71277961mm height=0.035mm)
  coil_tx_vertical_g2_b2_000000_e837_cab7_1 = polyline(y=0.3563898mm, xz in mm: (0.3563898, 550.64361) (146.00725, 550.64361) (146.00725, 544.35639) (0.3563898, 544.35639) (0.3563898, 549.25282) (1.7471793, 549.25282) (144.61646, 549.25282) (144.61646, 545.74718) (1.7471793, 545.74718), section rectangle width=0.71277961mm height=0.035mm)
  coil_tx_vertical_g3_b2_000000_e837_cab7_1 = polyline(y=3.5314286mm, xz in mm: (0.3563898, 550.64361) (146.00725, 550.64361) (146.00725, 544.35639) (0.3563898, 544.35639) (0.3563898, 549.25282) (1.7471793, 549.25282) (144.61646, 549.25282) (144.61646, 545.74718) (1.7471793, 545.74718), section rectangle width=0.71277961mm height=0.035mm)
  coil_tx_vertical_g4_b2_000000_e837_cab7_1 = polyline(y=7.0628571mm, xz in mm: (0.3563898, 550.64361) (146.00725, 550.64361) (146.00725, 544.35639) (0.3563898, 544.35639) (0.3563898, 549.25282) (1.7471793, 549.25282) (144.61646, 549.25282) (144.61646, 545.74718) (1.7471793, 545.74718), section rectangle width=0.71277961mm height=0.035mm)
  coil_rx_dd_g0_b3_000000_e837_cab7_1 = polyline(x=3.965mm, yz in mm: (-2.8752632, 712.87089) (-91.591404, 712.87089) (-91.591404, 602.97526) (-2.8752632, 602.97526) (-2.8752632, 699.70247) (-16.043684, 699.70247) (-78.422982, 699.70247) (-78.422982, 616.14369) (-16.043684, 616.14369), section rectangle width=3.9505263mm height=0.035mm)
  coil_rx_dd_g1_b4_000000_e837_cab7_1 = polyline(x=3.965mm, yz in mm: (2.8752632, 712.87089) (91.591404, 712.87089) (91.591404, 602.97526) (2.8752632, 602.97526) (2.8752632, 699.70247) (16.043684, 699.70247) (78.422982, 699.70247) (78.422982, 616.14369) (16.043684, 616.14369), section rectangle width=3.9505263mm height=0.035mm)
  rxs_rx_main_0_0_c [copper] = box(corner=(0.965mm, -18.018947mm, 614.16842mm), size=(3mm, 3.9505263mm, 3.9505263mm))
  coil_rx_dd_g0_b3_000000_e837_cab7_1_1 = coil_rx_dd_g0_b3_000000_e837_cab7_1.copy()
  rxs_rx_main_0_0_c.subtract(coil_rx_dd_g0_b3_000000_e837_cab7_1_1)
  rxs_rx_main_1_1_A [copper] = box(corner=(0.965mm, 0.9mm, 710.89563mm), size=(3mm, 3.9505263mm, 3.9505263mm))
  coil_rx_dd_g1_b4_000000_e837_cab7_1_1 = coil_rx_dd_g1_b4_000000_e837_cab7_1.copy()
  rxs_rx_main_1_1_A.subtract(coil_rx_dd_g1_b4_000000_e837_cab7_1_1)
  rxc_rx_main_0_0_B = box(corner=(2.965mm, -4.8505263mm, 710.89563mm), size=(1mm, 3.9505263mm, 3.9505263mm))
  coil_rx_dd_g0_b3_000000_e837_cab7_1.unite(rxc_rx_main_0_0_B)
  rxc_rx_main_1_1_d = box(corner=(2.965mm, 14.068421mm, 614.16842mm), size=(1mm, 3.9505263mm, 3.9505263mm))
  coil_rx_dd_g1_b4_000000_e837_cab7_1.unite(rxc_rx_main_1_1_d)
  bridge_rx_dd_d_to_b_000000_e837_cab7_1 [copper] = polyline(x=2.965mm, yz in mm: (14.068421, 614.16842) (14.068421, 618.11895) (-4.8505263, 714.84615) (-4.8505263, 710.89563) (14.068421, 614.16842), closed, covered)
  bridge_rx_dd_d_to_b_000000_e837_cab7_1.thicken(0.14mm)
  bridge_rx_dd_d_to_b_000000_e837_cab7_1.unite(coil_rx_dd_g0_b3_000000_e837_cab7_1, coil_rx_dd_g1_b4_000000_e837_cab7_1)
  txs_tx_main_0_0 [copper] = box(corner=(-4.4408921e-15mm, 92.574618mm, 540.31115mm), size=(5.6764044mm, 5.6764044mm, 3mm))
  coil_tx_dd_g1_b0_000000_e837_cab7_1_2 = coil_tx_dd_g1_b0_000000_e837_cab7_1.copy()
  txs_tx_main_0_0.subtract(coil_tx_dd_g1_b0_000000_e837_cab7_1_2)
  txs_tx_main_0_1 [copper] = box(corner=(19.531714mm, -27.269916mm, 540.31115mm), size=(5.6764044mm, 5.6764044mm, 3mm))
  coil_tx_dd_g1_b0_000000_e837_cab7_1_1_1 = coil_tx_dd_g1_b0_000000_e837_cab7_1_1.copy()
  txs_tx_main_0_1.subtract(coil_tx_dd_g1_b0_000000_e837_cab7_1_1_1)
  sheet_txdd_ports_tx_main_0 [copper] = polyline(z=540.31115mm, xy in mm: (-4.4408921e-15, 92.574618) (5.6764044, 92.574618) (25.208118, -27.269916) (19.531714, -27.269916) (-4.4408921e-15, 92.574618), closed, covered)
  sheet_rxdd_ports [copper] = polyline(x=0.965mm, yz in mm: (0.9, 710.89563) (0.9, 714.84615) (-18.018947, 618.11895) (-18.018947, 614.16842) (0.9, 710.89563), closed, covered)
  bridge_tx_vertical_link_g0_to_g1_b2_000000_e837_cab7_1 = polyline(xyz in mm: (0.71277961, -7.0628571, 550.28722) (0.71277961, -7.0628571, 551) (2.1035691, -3.5314286, 546.10357) (2.1035691, -3.5314286, 545.39079) (0.71277961, -7.0628571, 550.28722), closed, covered)
  bridge_tx_vertical_link_g0_to_g1_b2_000000_e837_cab7_1.thicken(0.14mm)
  bridge_tx_vertical_link_g1_to_g2_b2_000000_e837_cab7_1 = polyline(xyz in mm: (0.71277961, -3.5314286, 550.28722) (0.71277961, -3.5314286, 551) (2.1035691, 0.3563898, 546.10357) (2.1035691, 0.3563898, 545.39079) (0.71277961, -3.5314286, 550.28722), closed, covered)
  bridge_tx_vertical_link_g1_to_g2_b2_000000_e837_cab7_1.thicken(0.14mm)
  bridge_tx_vertical_link_g2_to_g3_b2_000000_e837_cab7_1 = polyline(xyz in mm: (0.71277961, 0.3563898, 550.28722) (0.71277961, 0.3563898, 551) (2.1035691, 3.5314286, 546.10357) (2.1035691, 3.5314286, 545.39079) (0.71277961, 0.3563898, 550.28722), closed, covered)
  bridge_tx_vertical_link_g2_to_g3_b2_000000_e837_cab7_1.thicken(0.14mm)
  bridge_tx_vertical_link_g3_to_g4_b2_000000_e837_cab7_1 = polyline(xyz in mm: (0.71277961, 3.5314286, 550.28722) (0.71277961, 3.5314286, 551) (2.1035691, 7.0628571, 546.10357) (2.1035691, 7.0628571, 545.39079) (0.71277961, 3.5314286, 550.28722), closed, covered)
  bridge_tx_vertical_link_g3_to_g4_b2_000000_e837_cab7_1.thicken(0.14mm)
  bridge_tx_vertical_link_g0_to_g1_b2_000000_e837_cab7_1.unite(bridge_tx_vertical_link_g1_to_g2_b2_000000_e837_cab7_1, bridge_tx_vertical_link_g2_to_g3_b2_000000_e837_cab7_1, bridge_tx_vertical_link_g3_to_g4_b2_000000_e837_cab7_1, coil_tx_vertical_g0_b2_000000_e837_cab7_1, coil_tx_vertical_g1_b2_000000_e837_cab7_1, coil_tx_vertical_g2_b2_000000_e837_cab7_1, coil_tx_vertical_g3_b2_000000_e837_cab7_1, coil_tx_vertical_g4_b2_000000_e837_cab7_1)
  bridge_tx_dd_to_tx_vertical_000000_e837_cab7_1 = polyline(xyz in mm: (25.208118, 24.431714, 543.31115) (19.531714, 24.431714, 543.31115) (0.3563898, 7.0628571, 550.28722) (0.3563898, 7.0628571, 551) (25.208118, 24.431714, 543.31115), closed, covered)
  bridge_tx_dd_to_tx_vertical_000000_e837_cab7_1.thicken(0.14mm)
  bridge_tx_dd_to_tx_vertical_000000_e837_cab7_1.unite(bridge_tx_vertical_link_g0_to_g1_b2_000000_e837_cab7_1, coil_tx_dd_g1_b0_000000_e837_cab7_1)
  bridge_tx_dd_left_to_tx_vertical_000000_e837_cab7_1 [copper] = polyline(xyz in mm: (5.6764044, -95.412821, 543.31115) (-4.4408921e-15, -95.412821, 543.31115) (1.7471793, -7.0628571, 545.39079) (1.7471793, -7.0628571, 546.10357) (5.6764044, -95.412821, 543.31115), closed, covered)
  bridge_tx_dd_left_to_tx_vertical_000000_e837_cab7_1.thicken(0.14mm)
  bridge_tx_dd_left_to_tx_vertical_000000_e837_cab7_1.unite(bridge_tx_dd_to_tx_vertical_000000_e837_cab7_1, coil_tx_dd_g1_b0_000000_e837_cab7_1_1)
  fr4_rx_main_0_yz_0_000000_e837_cab7_1 [FR4_epoxy] = box(corner=(2.2475mm, -93.666667mm, 600.900001mm), size=(1.6mm, 92.866667mm, 114.04615mm))
  fr4_rx_main_1_yz_1_000000_e837_cab7_1 [FR4_epoxy] = box(corner=(2.2475mm, 0.8mm, 600.900001mm), size=(1.6mm, 92.866667mm, 114.04615mm))
  bridge_rx_dd_d_to_b_000000_e837_cab7_1_1 = bridge_rx_dd_d_to_b_000000_e837_cab7_1.copy()
  fr4_rx_main_0_yz_0_000000_e837_cab7_1.subtract(bridge_rx_dd_d_to_b_000000_e837_cab7_1_1)
  rxs_rx_main_0_0_c_1 = rxs_rx_main_0_0_c.copy()
  fr4_rx_main_0_yz_0_000000_e837_cab7_1.subtract(rxs_rx_main_0_0_c_1)
  rxs_rx_main_1_1_A_1 = rxs_rx_main_1_1_A.copy()
  fr4_rx_main_0_yz_0_000000_e837_cab7_1.subtract(rxs_rx_main_1_1_A_1)
  bridge_rx_dd_d_to_b_000000_e837_cab7_1_2 = bridge_rx_dd_d_to_b_000000_e837_cab7_1.copy()
  fr4_rx_main_1_yz_1_000000_e837_cab7_1.subtract(bridge_rx_dd_d_to_b_000000_e837_cab7_1_2)
  rxs_rx_main_0_0_c_2 = rxs_rx_main_0_0_c.copy()
  fr4_rx_main_1_yz_1_000000_e837_cab7_1.subtract(rxs_rx_main_0_0_c_2)
  rxs_rx_main_1_1_A_2 = rxs_rx_main_1_1_A.copy()
  fr4_rx_main_1_yz_1_000000_e837_cab7_1.subtract(rxs_rx_main_1_1_A_2)
  bridge_tx_dd_left_to_tx_vertical_000000_e837_cab7_1_1 = bridge_tx_dd_left_to_tx_vertical_000000_e837_cab7_1.copy()
  bridge_tx_dd_left_to_tx_vertical_000000_e837_cab7_1_1.delete()
  txs_tx_main_0_0_1 = txs_tx_main_0_0.copy()
  txs_tx_main_0_0_1.delete()
  txs_tx_main_0_1_1 = txs_tx_main_0_1.copy()
  txs_tx_main_0_1_1.delete()
  bridge_tx_dd_left_to_tx_vertical_000000_e837_cab7_1_2 = bridge_tx_dd_left_to_tx_vertical_000000_e837_cab7_1.copy()
  bridge_tx_dd_left_to_tx_vertical_000000_e837_cab7_1_2.delete()
  txs_tx_main_0_0_2 = txs_tx_main_0_0.copy()
  txs_tx_main_0_0_2.delete()
  txs_tx_main_0_1_2 = txs_tx_main_0_1.copy()
  txs_tx_main_0_1_2.delete()
  Region_Abs_3500mm [air] = region(absolute_offset=3500mm on all sides)
  fr4_tx_main_0_xy_2_000000_e837_cab7_1, fr4_tx_vertical_0_zx_3_000000_e837_cab7_1 [FR4_epoxy] = imported_body()
  Box1 [vacuum, non-model] = box(corner=(160mm, 140mm, 461mm), size=(-160mm, -280mm, 253.84615mm))
  Box2 [vacuum, non-model] = box(corner=(-0.1mm, -8.7803571mm, 551.1mm), size=(146.56364mm, 15.725714mm, -7.2mm))
  group Tx = txs_tx_main_0_0, txs_tx_main_0_1, bridge_tx_dd_left_to_tx_vertical_000000_e837_cab7_1
  group Rx = rxs_rx_main_0_0_c, rxs_rx_main_1_1_A, bridge_rx_dd_d_to_b_000000_e837_cab7_1
  group Fr4 = fr4_rx_main_0_yz_0_000000_e837_cab7_1, fr4_rx_main_1_yz_1_000000_e837_cab7_1, fr4_tx_main_0_xy_2_000000_e837_cab7_1, fr4_tx_vertical_0_zx_3_000000_e837_cab7_1
boundaries and excitations:
  Rad_RegionAbs_0: Radiation Faces=Region_Abs_3500mm.face(+z)
  Rad_RegionAbs_1: Radiation Faces=Region_Abs_3500mm.face(-y)
  Rad_RegionAbs_2: Radiation Faces=Region_Abs_3500mm.face(-x)
  Rad_RegionAbs_3: Radiation Faces=Region_Abs_3500mm.face(+y)
  Rad_RegionAbs_4: Radiation Faces=Region_Abs_3500mm.face(-z)
  Rad_RegionAbs_5: Radiation Faces=Region_Abs_3500mm.face(+x)
  txs_tx_main_0_0_T1: Terminal port=TX_TML Edges=txs_tx_main_0_0.edge(at (2.8382, 92.5746, 540.311)) TerminalResistance=50ohm
  rxs_rx_main_1_1_A_T1: Terminal port=RX_TML Edges=rxs_rx_main_1_1_A.edge(at (0.965, 0.9, 712.871)) TerminalResistance=50ohm
  TX_TML: Lumped Port Faces=sheet_txdd_ports_tx_main_0.face LumpedPortType=Terminal Impedance=50ohm
  RX_TML: Lumped Port Faces=sheet_rxdd_ports.face LumpedPortType=Terminal Impedance=50ohm
  reference conductors: rxs_rx_main_0_0_c
setups:
  Setup1: HfssDriven Frequency=6.78MHz MaxDeltaS=0.007 MaximumPasses=5 MinimumPasses=1 MinimumConvergedPasses=1 PercentRefinement=20 BasisOrder=1 MaxTetIncrease=700000 PortAccuracy=2 DrivenSolverType="Direct Solver"
source amplitudes:
  TX_TML:1: 1V 0deg
  RX_TML:1: 1V 90deg
output variables:
  Ltx_uH = im(Zt(txs_tx_main_0_0_T1,txs_tx_main_0_0_T1))/2/pi/freq*1e6
  Lrx_uH = im(Zt(rxs_rx_main_1_1_A_T1,rxs_rx_main_1_1_A_T1))/2/pi/freq*1e6
  M_uH = abs(im(Zt(txs_tx_main_0_0_T1,rxs_rx_main_1_1_A_T1))/2/pi/freq*1e6)
  k_ratio = M_uH/sqrt(Ltx_uH*Lrx_uH)
  Qtx_ratio = im(Zt(txs_tx_main_0_0_T1,txs_tx_main_0_0_T1))/re(Zt(txs_tx_main_0_0_T1,txs_tx_main_0_0_T1))
  Qrx_ratio = im(Zt(rxs_rx_main_1_1_A_T1,rxs_rx_main_1_1_A_T1))/re(Zt(rxs_rx_main_1_1_A_T1,rxs_rx_main_1_1_A_T1))
  FOM_ratio = k_ratio*sqrt(Qtx_ratio*Qrx_ratio)
  Rtx_ac_ohm = re(Zt(txs_tx_main_0_0_T1,txs_tx_main_0_0_T1))
  Rrx_ac_ohm = re(Zt(rxs_rx_main_1_1_A_T1,rxs_rx_main_1_1_A_T1))
  Xtx_ohm = im(Zt(txs_tx_main_0_0_T1,txs_tx_main_0_0_T1))
  Xrx_ohm = im(Zt(rxs_rx_main_1_1_A_T1,rxs_rx_main_1_1_A_T1))
  M_over_Ltx_ratio = M_uH/Ltx_uH
  M_over_Lrx_ratio = M_uH/Lrx_uH
  Gtx_S = re(Yt(txs_tx_main_0_0_T1,txs_tx_main_0_0_T1))
  Btx_S = im(Yt(txs_tx_main_0_0_T1,txs_tx_main_0_0_T1))
  Grx_S = re(Yt(rxs_rx_main_1_1_A_T1,rxs_rx_main_1_1_A_T1))
  Brx_S = im(Yt(rxs_rx_main_1_1_A_T1,rxs_rx_main_1_1_A_T1))
  S11_mag_ratio = mag(St(txs_tx_main_0_0_T1,txs_tx_main_0_0_T1))
  S21_mag_ratio = mag(St(txs_tx_main_0_0_T1,rxs_rx_main_1_1_A_T1))
  S21_phase_deg = ang_deg_val(St(txs_tx_main_0_0_T1,rxs_rx_main_1_1_A_T1))
  S22_mag_ratio = mag(St(rxs_rx_main_1_1_A_T1,rxs_rx_main_1_1_A_T1))
  eta_s21_power_ratio = S21_mag_ratio*S21_mag_ratio
  eta_tx_accept_ratio = 1-S11_mag_ratio*S11_mag_ratio
  eta_rx_accept_ratio = 1-S22_mag_ratio*S22_mag_ratio
  eta_match_product_ratio = eta_tx_accept_ratio*eta_rx_accept_ratio
  eta_s21_from_tx_accept_ratio = eta_s21_power_ratio/eta_tx_accept_ratio
  eta_s21_from_rx_accept_ratio = eta_s21_power_ratio/eta_rx_accept_ratio
  eta_s21_two_sided_norm_ratio = eta_s21_power_ratio/(eta_tx_accept_ratio*eta_rx_accept_ratio)
  eta_fom_max_ratio = (FOM_ratio*FOM_ratio)/((1+sqrt(1+FOM_ratio*FOM_ratio))*(1+sqrt(1+FOM_ratio*FOM_ratio)))
reports:
  Output Variables Table1: Ltx_uH, Lrx_uH, M_uH, k_ratio, Qtx_ratio, Qrx_ratio, FOM_ratio, Rtx_ac_ohm, Rrx_ac_ohm, Xtx_ohm, Xrx_ohm, M_over_Ltx_ratio, M_over_Lrx_ratio, Gtx_S, Btx_S, Grx_S, Brx_S, S11_mag_ratio, S21_mag_ratio, S21_phase_deg, S22_mag_ratio, eta_s21_power_ratio, eta_tx_accept_ratio, eta_rx_accept_ratio, eta_match_product_ratio, eta_s21_from_tx_accept_ratio, eta_s21_from_rx_accept_ratio, eta_s21_two_sided_norm_ratio, eta_fom_max_ratio vs Freq on Setup1 : LastAdaptive
